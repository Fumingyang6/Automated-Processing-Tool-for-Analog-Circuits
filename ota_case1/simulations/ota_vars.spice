.param W_M0=10.08 L_M0=1.2076436281204224 M_M0=3
.param W_M1=9.66 L_M1=0.9068984836339951 M_M1=3
.param W_M2=9.66 L_M2=0.9068984836339951 M_M2=3
.param W_M3=9.66 L_M3=0.949600338935852 M_M3=4
.param W_M4=9.66 L_M4=0.949600338935852 M_M4=4
.param W_M5=10.08 L_M5=1.2076436281204224 M_M5=3
.param W_M6=6.72 L_M6=1.0750989243388176 M_M6=5
.param Vb=1.4187399834394454
.param VDD=5
.param GND=0
