subckt   OPA_my    GND  VDD VB VOUT VIN VIP

M7 (net103 net96 net98 GND) nch_lvt w=2u l=5u nf=1 multi=1     ****OPA_my_M7 match with OPA_my_M8, group1(OPA_my_M3\OPA_my_M4\OPA_my_M2\OPA_my_M5\OPA_my_M0\OPA_my_M1\OPA_my_M11\OPA_my_M9\OPA_my_M15\OPA_my_M6\OPA_my_M7\OPA_my_M8\OPA_my_M10\OPA_my_M12), group2(OPA_my_M0\OPA_my_M1\OPA_my_M11\OPA_my_M9), group3(OPA_my_M15\OPA_my_M6\OPA_my_M7\OPA_my_M8)
M6 (net103 net98 net116 GND) nch_lvt w=2u l=5u nf=1 multi=1     ****OPA_my_M15 match with OPA_my_M6, group1(OPA_my_M3\OPA_my_M4\OPA_my_M2\OPA_my_M5\OPA_my_M0\OPA_my_M1\OPA_my_M11\OPA_my_M9\OPA_my_M15\OPA_my_M6\OPA_my_M7\OPA_my_M8\OPA_my_M10\OPA_my_M12), group2(OPA_my_M0\OPA_my_M1\OPA_my_M11\OPA_my_M9), group3(OPA_my_M15\OPA_my_M6\OPA_my_M7\OPA_my_M8)
M15 (net98 net98 net117 GND) nch_lvt w=2u l=5u nf=1 multi=1     ****OPA_my_M15 match with OPA_my_M6, group1(OPA_my_M3\OPA_my_M4\OPA_my_M2\OPA_my_M5\OPA_my_M0\OPA_my_M1\OPA_my_M11\OPA_my_M9\OPA_my_M15\OPA_my_M6\OPA_my_M7\OPA_my_M8\OPA_my_M10\OPA_my_M12), group2(OPA_my_M0\OPA_my_M1\OPA_my_M11\OPA_my_M9), group3(OPA_my_M15\OPA_my_M6\OPA_my_M7\OPA_my_M8)
M8 (net96 net98 GND GND) nch_lvt w=2u l=5u nf=1 multi=1     ****OPA_my_M7 match with OPA_my_M8, group1(OPA_my_M3\OPA_my_M4\OPA_my_M2\OPA_my_M5\OPA_my_M0\OPA_my_M1\OPA_my_M11\OPA_my_M9\OPA_my_M15\OPA_my_M6\OPA_my_M7\OPA_my_M8\OPA_my_M10\OPA_my_M12), group2(OPA_my_M0\OPA_my_M1\OPA_my_M11\OPA_my_M9), group3(OPA_my_M15\OPA_my_M6\OPA_my_M7\OPA_my_M8)
R0 (GND net116) rppolywo l=5.5u w=20u series=6 segspace=250n
C0 (net111 VOUT) cfmom nr=60 l=8u w=5u s=70n stm=1 spm=6 multi=1 ftip=140.0n dmflag=0
M9 (net97 net97 VDD VDD) pch w=3.5u l=5u  nf=1 multi=1     ****OPA_my_M11 match with OPA_my_M9, group1(OPA_my_M3\OPA_my_M4\OPA_my_M2\OPA_my_M5\OPA_my_M0\OPA_my_M1\OPA_my_M11\OPA_my_M9\OPA_my_M15\OPA_my_M6\OPA_my_M7\OPA_my_M8\OPA_my_M10\OPA_my_M12), group2(OPA_my_M0\OPA_my_M1\OPA_my_M11\OPA_my_M9), group3(OPA_my_M15\OPA_my_M6\OPA_my_M7\OPA_my_M8)
M10 (net108 net103 VDD VDD) pch w=4u l=2u nf=1 multi=1     ****OPA_my_M10 match with OPA_my_M12, group1(OPA_my_M3\OPA_my_M4\OPA_my_M2\OPA_my_M5\OPA_my_M0\OPA_my_M1\OPA_my_M11\OPA_my_M9\OPA_my_M15\OPA_my_M6\OPA_my_M7\OPA_my_M8\OPA_my_M10\OPA_my_M12), group2(OPA_my_M0\OPA_my_M1\OPA_my_M11\OPA_my_M9), group3(OPA_my_M15\OPA_my_M6\OPA_my_M7\OPA_my_M8)
M11 (VOUT net103 VDD VDD) pch w=3.5u l=5u  nf=1 multi=1     ****OPA_my_M11 match with OPA_my_M9, group1(OPA_my_M3\OPA_my_M4\OPA_my_M2\OPA_my_M5\OPA_my_M0\OPA_my_M1\OPA_my_M11\OPA_my_M9\OPA_my_M15\OPA_my_M6\OPA_my_M7\OPA_my_M8\OPA_my_M10\OPA_my_M12), group2(OPA_my_M0\OPA_my_M1\OPA_my_M11\OPA_my_M9), group3(OPA_my_M15\OPA_my_M6\OPA_my_M7\OPA_my_M8)
M12 (net103 net103 VDD VDD) pch w=4u l=2u nf=1 multi=1     ****OPA_my_M10 match with OPA_my_M12, group1(OPA_my_M3\OPA_my_M4\OPA_my_M2\OPA_my_M5\OPA_my_M0\OPA_my_M1\OPA_my_M11\OPA_my_M9\OPA_my_M15\OPA_my_M6\OPA_my_M7\OPA_my_M8\OPA_my_M10\OPA_my_M12), group2(OPA_my_M0\OPA_my_M1\OPA_my_M11\OPA_my_M9), group3(OPA_my_M15\OPA_my_M6\OPA_my_M7\OPA_my_M8)
M13 (net98 net103 VDD VDD) pch w=1.2u l=1.2u nf=1 multi=4
M14 (net96 net98 net97 VDD) pch w=1.2u l=1.2u nf=1 multi=4
M5 (net117 GND GND GND) nch_lvt w=3.5u l=5u nf=1   multi=1     ****OPA_my_M2 match with OPA_my_M5, group1(OPA_my_M3\OPA_my_M4\OPA_my_M2\OPA_my_M5\OPA_my_M0\OPA_my_M1\OPA_my_M11\OPA_my_M9\OPA_my_M15\OPA_my_M6\OPA_my_M7\OPA_my_M8\OPA_my_M10\OPA_my_M12), group2(OPA_my_M0\OPA_my_M1\OPA_my_M11\OPA_my_M9), group3(OPA_my_M15\OPA_my_M6\OPA_my_M7\OPA_my_M8)
M2 (net105 net105 GND GND) nch_lvt w=3.5u l=5u nf=1 multi=1     ****OPA_my_M2 match with OPA_my_M5, group1(OPA_my_M3\OPA_my_M4\OPA_my_M2\OPA_my_M5\OPA_my_M0\OPA_my_M1\OPA_my_M11\OPA_my_M9\OPA_my_M15\OPA_my_M6\OPA_my_M7\OPA_my_M8\OPA_my_M10\OPA_my_M12), group2(OPA_my_M0\OPA_my_M1\OPA_my_M11\OPA_my_M9), group3(OPA_my_M15\OPA_my_M6\OPA_my_M7\OPA_my_M8)
M1 (net105 VIN net108 net108) pch w=3.5u l=5u nf=1 multi=1     ****OPA_my_M0 match with OPA_my_M1, group1(OPA_my_M3\OPA_my_M4\OPA_my_M2\OPA_my_M5\OPA_my_M0\OPA_my_M1\OPA_my_M11\OPA_my_M9\OPA_my_M15\OPA_my_M6\OPA_my_M7\OPA_my_M8\OPA_my_M10\OPA_my_M12), group2(OPA_my_M0\OPA_my_M1\OPA_my_M11\OPA_my_M9), group3(OPA_my_M15\OPA_my_M6\OPA_my_M7\OPA_my_M8)
M0 (net111 VIP net108 net108) pch w=3.5u l=5u nf=1 multi=1     ****OPA_my_M0 match with OPA_my_M1, group1(OPA_my_M3\OPA_my_M4\OPA_my_M2\OPA_my_M5\OPA_my_M0\OPA_my_M1\OPA_my_M11\OPA_my_M9\OPA_my_M15\OPA_my_M6\OPA_my_M7\OPA_my_M8\OPA_my_M10\OPA_my_M12), group2(OPA_my_M0\OPA_my_M1\OPA_my_M11\OPA_my_M9), group3(OPA_my_M15\OPA_my_M6\OPA_my_M7\OPA_my_M8)
M3 (VOUT net111 GND GND) nch_lvt w=4u l=1u nf=1 multi=1     ****OPA_my_M3 match with OPA_my_M4, group1(OPA_my_M3\OPA_my_M4\OPA_my_M2\OPA_my_M5\OPA_my_M0\OPA_my_M1\OPA_my_M11\OPA_my_M9\OPA_my_M15\OPA_my_M6\OPA_my_M7\OPA_my_M8\OPA_my_M10\OPA_my_M12), group2(OPA_my_M0\OPA_my_M1\OPA_my_M11\OPA_my_M9), group3(OPA_my_M15\OPA_my_M6\OPA_my_M7\OPA_my_M8)
M4 (net111 net105 GND GND) nch_lvt w=4u l=1u nf=1  multi=1     ****OPA_my_M3 match with OPA_my_M4, group1(OPA_my_M3\OPA_my_M4\OPA_my_M2\OPA_my_M5\OPA_my_M0\OPA_my_M1\OPA_my_M11\OPA_my_M9\OPA_my_M15\OPA_my_M6\OPA_my_M7\OPA_my_M8\OPA_my_M10\OPA_my_M12), group2(OPA_my_M0\OPA_my_M1\OPA_my_M11\OPA_my_M9), group3(OPA_my_M15\OPA_my_M6\OPA_my_M7\OPA_my_M8)
ends  OPA_my
