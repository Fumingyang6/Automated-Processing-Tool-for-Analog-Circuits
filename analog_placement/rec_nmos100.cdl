 ************************************************************************
* Library Name: CD2101_HF
* Cell Name:    rec_nmos100
* View Name:    schematic
************************************************************************

 .SUBCKT rec_nmos100 A1 A3 A4 RF_Dout VDD anten1 anten2 gnd
*.PININFO RF_Dout:I VDD:I anten1:I anten2:I gnd:I A1:O A3:O A4:O
XNM2 net105 net101 gnd gnd n18_ckt MR=2 NF=1 L=180n W=4u
XNM0 net101 RF_Dout gnd gnd n18_ckt MR=2 NF=1 L=180n W=4u
XR17 anten1 net050 rpposab_ckt_p W=1u L=6.263u MR=5   $$$$$
XR16 anten1 net050 rpposab_ckt_p W=1u L=6.263u MR=5   $$$$$
XR15 anten1 net050 rpposab_ckt_p W=1u L=6.263u MR=5   $$$$$
XR14 anten1 net050 rpposab_ckt_p W=1u L=6.263u MR=5   $$$$$
XR13 anten2 net049 rpposab_ckt_p W=1u L=6.263u MR=5   $$$$$
XR12 anten2 net049 rpposab_ckt_p W=1u L=6.263u MR=5   $$$$$
XR10 anten2 net049 rpposab_ckt_p W=1u L=6.263u MR=5   $$$$$
XR11 anten2 net049 rpposab_ckt_p W=1u L=6.263u MR=5   $$$$$
XR1 net054 gnd rpposab_ckt W=2u L=10.775u MR=100
XR7 a2 net044 rpposab_ckt_p W=600n L=7.497u MR=5 $$$$$
XC1 net044 net054 mim2_ckt LR=8u WR=24u MR=2
XM2 net030 net92 a2 a2 p50_ckt MR=2 NF=1 L=800n W=4u
XM3 net030 net030 a2 a2 p50_ckt MR=1 NF=1 L=1u W=2u
XM4 net054 net054 net030 net030 p50_ckt MR=2 NF=1 L=1u W=5u
XM1 net34 net92 A1 A1 p50_ckt MR=1 NF=1 L=800n W=10u
XM0 net92 net34 A1 A1 p50_ckt MR=1 NF=1 L=800n W=10u
XM25 net049 net34 gnd gnd n50_ckt MR=10 NF=1 L=1u W=10u
XM26 net050 net34 gnd gnd n50_ckt MR=10 NF=1 L=1u W=10u
XM23 net92 net101 gnd gnd n50_ckt MR=2 NF=1 L=600n W=10u
XM14 anten2 net054 gnd gnd n50_ckt MR=50 NF=1 L=1u W=10u
XM24 net34 net105 gnd gnd n50_ckt MR=2 NF=1 L=600n W=10u
XM13 anten1 net054 gnd gnd n50_ckt MR=50 NF=1 L=1u W=10u
XM30 anten1 anten1 A1 gnd n50_ckt MR=5 NF=1 L=1u W=10u
XM31 anten2 anten2 A1 gnd n50_ckt MR=5 NF=1 L=1u W=10u
XM29 anten1 anten2 gnd gnd n50_ckt MR=50 NF=1 L=1u W=10u
XM27 anten2 anten2 a2 gnd n50_ckt MR=1 NF=1 L=1u W=10u
XM28 anten2 anten1 gnd gnd n50_ckt MR=50 NF=1 L=1u W=10u
XM19 anten1 anten1 a2 gnd n50_ckt MR=1 NF=1 L=1u W=10u
XM16 anten1 anten1 A3 gnd n50_ckt MR=1 NF=1 L=1u W=10u
XM15 anten2 anten2 A3 gnd n50_ckt MR=1 NF=1 L=1u W=10u
XM33 anten1 anten1 A4 gnd n50_ckt MR=1 NF=1 L=1u W=10u
XM32 anten2 anten2 A4 gnd n50_ckt MR=1 NF=1 L=1u W=10u
XPM2 net105 net101 VDD VDD p18_ckt MR=2 NF=1 L=180n W=4u
XPM0 net101 RF_Dout VDD VDD p18_ckt MR=2 NF=1 L=180n W=4u
.ENDS
