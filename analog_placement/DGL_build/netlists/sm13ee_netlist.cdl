************************************************************************
* auCdl Netlist:
*
* Library Name:  CD2101
* Top Cell Name: CD2001SLX2_A
* View Name:     schematic
* Netlisted on:  Mar 31 10:13:21 2025
************************************************************************

*.BIPOLAR
*.RESI = 2000
*.RESVAL
*.CAPVAL
*.DIOPERI
*.DIOAREA
*.EQUATION
*.SCALE METER
*.MEGA
.PARAM

************************************************************************
* Library Name: CD2101
* Cell Name:    compare_wv20200529
* View Name:    schematic
************************************************************************

.SUBCKT compare_wv20200529 Rf_dout Vb dem10_sen1 dem10_sen2 vdd vinn vinp vss
*.PININFO Vb:I dem10_sen1:I dem10_sen2:I vinn:I vinp:I Rf_dout:O vdd:B vss:B
RR2 net14 net0108 0 $[RP]
RR0 Vb net05 0 $[RP]
RR1 net056 net059 80K $[rpposab] $W=2u $L=499.332u M=1
MPM20 net056 net095 vdd vdd p15ll W=2u L=600n M=2
MPM21 Rf_dout net096 vdd vdd p15ll W=4.8u L=600n M=1
MPM18 net095 net033 vdd vdd p15ll W=600n L=600n M=1
MPM17 net096 net097 vdd vdd p15ll W=4.8u L=600n M=1
MPM16 net097 net059 vdd vdd p15ll W=600n L=5u M=1
MPM15 net097 net095 vdd vdd p15ll W=600n L=5u M=1
MPM1 net030 net041 vdd vdd p15ll W=2u L=1u M=1
MPM8 net0198 net14 vdd vdd p15ll W=5u L=2u M=1
MPM9 net0193 net56 vdd vdd p15ll W=5u L=2u M=1
MPM7 net56 net56 vdd vdd p15ll W=1u L=9u M=1
MPM10 net0111 net0111 vdd vdd p15ll W=10u L=5u M=1
MPM6 net14 net14 vdd vdd p15ll W=1u L=9u M=1
MPM11 net041 net0111 vdd vdd p15ll W=12u L=5u M=1
MPM5 net0106 net097 vdd vdd p15ll W=600n L=600n M=1
MPM36 net033 net030 vdd vdd p15ll W=5u L=500n M=1
XC0 net059 vss pipe2r_ckt M=4 W=10u L=19.263u
XC1 net041 vss pipe2r_ckt M=1 W=9.632u L=20u
XC6 net0193 vss pipe2r_ckt M=1 W=10u L=19.263u
XC3 vdd net14 pipe2r_ckt M=1 W=22.693u L=22.693u
XC2 vdd net56 pipe2r_ckt M=1 W=22.693u L=22.693u
XC4 net0198 vss pipe2r_ckt M=1 W=9.632u L=20u
MNM28 net0107 net097 vss vss n15ll W=600n L=600n M=1
MNM22 net05 net05 vss vss n15ll W=2u L=500n M=1
MNM21 Rf_dout net096 vss vss n15ll W=2.4u L=600n M=1
MNM5 net097 net059 net091 vss n15ll W=3.6u L=600n M=1
MNM6 net096 net097 vss vss n15ll W=2.4u L=600n M=1
MNM19 net095 net033 vss vss n15ll W=600n L=600n M=1
MNM1 net085 net041 vss vss n15ll W=500n L=2u M=1
MNM18 net056 net095 vss vss n15ll W=2u L=1u M=1
MNM3 net0193 dem10_sen1 net0103 vss n15ll W=5u L=130n M=1
MNM7 net0103 net0198 vss vss n15ll W=10u L=2u M=1
MNM8 net0101 net0193 vss vss n15ll W=10u L=2u M=1
MNM20 net0198 dem10_sen1 net0101 vss n15ll W=5u L=130n M=1
MNM23 net099 net0198 vss vss n15ll W=10u L=2u M=1
MNM24 net0193 dem10_sen2 net099 vss n15ll W=5u L=130n M=1
MNM4 net091 net095 vss vss n15ll W=3.6u L=600n M=1
MNM25 net098 net0193 vss vss n15ll W=10u L=2u M=1
MNM9 net0193 net0193 vss vss n15ll W=50u L=2u M=1
MPM14 net0198 net0198 vss vss n15ll W=50u L=2u M=1
MNM11 net0193 net0198 vss vss n15ll W=10u L=2u M=1
MNM10 net0198 net0193 vss vss n15ll W=10u L=2u M=1
MNM14 net0151 net05 vss vss n15ll W=2u L=500n M=1
MNM15 net0111 net0198 vss vss n15ll W=40u L=500n M=1
MNM42 net033 net030 vss vss n15ll W=10u L=1u M=1
MNM2 net081 net041 net085 vss n15ll W=500n L=2u M=1
MNM26 net0198 dem10_sen2 net098 vss n15ll W=5u L=130n M=1
MNM41 net030 net041 net081 vss n15ll W=500n L=2u M=1
MNM16 net041 net0193 vss vss n15ll W=40u L=500n M=1
MNM12 net56 vinn net0151 vss n15ll W=20u L=500n M=1
MNM13 net0108 vinp net0151 vss n15ll W=20u L=500n M=1
.ENDS

************************************************************************
* Library Name: CD2101
* Cell Name:    dem_v6_wv1
* View Name:    schematic
************************************************************************

.SUBCKT dem_v6_wv1 A1 Rf_dout Rf_dout2 VDD Vb1 decode10_en decode_en2
+ dem10_sen1 dem10_sen2 dem_in gnd
*.PININFO A1:I VDD:I Vb1:I decode10_en:I decode_en2:I dem10_sen1:I
*.PININFO dem10_sen2:I dem_in:I gnd:I Rf_dout:O Rf_dout2:O
MM6 net037 decode10_en Vb2 gnd n15ll W=1.5u L=130n M=1
MM8 decode10_enn decode10_en gnd gnd n15ll W=150n L=130n M=1
MNM0 Vb2 decode10_enn gnd gnd n15ll W=150n L=130n M=1
MNM3 gnd netb gnd gnd n15ll W=5u L=5u M=16
MNM1 gnd neta gnd gnd n15ll W=5u L=5u M=4
MM7 net037 decode10_enn Vb2 VDD p15ll W=1.5u L=130n M=1
MM9 decode10_enn decode10_en VDD VDD p15ll W=150n L=130n M=1
XC0 net036 gnd pipe2r_ckt M=1 W=17.229u L=22.361u
MM1 Vb1 decode_enn2 net037 A1 p33e2r W=6u L=800n M=1
MM3 decode_enn2 decode_en2 A1 A1 p33e2r W=600n L=800n M=1
MM2 Vb1 decode_en2 net037 gnd n33e2r W=6u L=600n M=1
MM4 decode_enn2 decode_en2 gnd gnd n33e2r W=600n L=600n M=1
MM5 net037 decode_enn2 gnd gnd n33e2r W=600n L=600n M=1
MM0 net016 net016 net038 gnd n33e2r W=2u L=600n M=1
MM10 net038 decode10_en gnd gnd n33e2r W=2u L=600n M=1
RR7 net036 netb 500K $[RP]
RR6 net036 net016 30K $[RP]
RR5 dem_in net036 150K $[RP]
RR0 net036 neta 250K $[RP]
XI106 Rf_dout2 Vb2 dem10_sen1 dem10_sen2 VDD neta netb gnd / compare_wv20200529
XI107 Rf_dout Vb2 dem10_sen1 dem10_sen2 VDD netb neta gnd / compare_wv20200529
.ENDS

************************************************************************
* Library Name: CD2101
* Cell Name:    LDO_NTAG
* View Name:    schematic
************************************************************************

.SUBCKT LDO_NTAG SELVD VDD VHD gnd por vbias vbias2
*.PININFO SELVD:I VHD:I gnd:I VDD:O por:O vbias:O vbias2:O
*.CONNECT VDD net066
MNM5 net063 net036 gnd gnd n15ll W=150n L=10u M=1
MNM3 net054 net051 gnd gnd n15ll W=150n L=130n M=5
MNM1 net051 net035 gnd gnd n15ll W=150n L=130n M=5
MNM0 net035 net036 net063 gnd n15ll W=150n L=10u M=1
MNM4 por net054 gnd gnd n15ll W=150n L=130n M=10
MMN52 net_03 net_01 gnd gnd n15ll W=9u L=1u M=1
MMN51 net_01 net_01 gnd gnd n15ll W=3u L=1u M=1
MMN53 net_02 net_01 net_03 gnd n15ll W=21u L=1u M=1
XQ1 gnd gnd net_bias2 pnp18a4_mis_ckt M=1 AREA=4e-12
XC2 gnd net036 pipe2r_ckt M=2 W=10u L=38.526u
XC3 VDD net_03 pipe2r_ckt M=2 W=10u L=38.526u
RR2 net036 VDD 500K $[RP]
RR0 net_bias3 gnd 200K $[RP]
RR9 VHD net085 560K $[RP]
MM0 vbias2 vbias VHD VHD p33e2r W=3u L=3u M=1
MMP48 net_01 vbias VHD VHD p33e2r W=3u L=3u M=1
MMP49 net_02 vbias VHD VHD p33e2r W=3u L=3u M=1
MMP50 VDD net_02 VHD VHD p33e2r W=30u L=800n M=1
MMP5 net_bias4 net_bias1 net085 VHD p33e2r W=3u L=3u M=1
MMP4 vbias vbias VHD VHD p33e2r W=6u L=3u M=1
MMP3 net_bias1 vbias VHD VHD p33e2r W=6u L=3u M=1
MMN7 vbias net_bias4 gnd gnd n33e2r W=3u L=3u M=1
MMN6 net_bias4 net_bias1 gnd gnd n33e2r W=3u L=3u M=1
MMN1 net_bias1 net_bias1 net_bias2 gnd n33e2r W=6u L=3u M=1
MMN2 vbias net_bias1 net_bias3 gnd n33e2r W=6u L=3u M=1
MPM26 net061 SELVD VDD VDD p15ll W=2u L=180n M=1
MPM25 net_03 net_01 net061 VDD p15ll W=1u L=4u M=1
MPM3 net054 net051 VDD VDD p15ll W=150n L=130n M=5
MPM1 net051 net035 VDD VDD p15ll W=150n L=130n M=5
MPM0 net035 net036 VDD VDD p15ll W=1u L=300n M=10
MPM4 por net054 VDD VDD p15ll W=150n L=130n M=10
MMP54 net_03 net_01 VDD VDD p15ll W=1u L=4.5u M=1
.ENDS

************************************************************************
* Library Name: CD2101
* Cell Name:    clk
* View Name:    schematic
************************************************************************

.SUBCKT clk VDD anten1 anten2 clk gnd
*.PININFO VDD:I anten1:I anten2:I gnd:I clk:O
MM0 net063 net030 gnd gnd n33e2r W=20u L=800n M=1
MM1 net24 net031 gnd gnd n33e2r W=20u L=800n M=1
MPM0 clk net016 VDD VDD p15ll W=3u L=130n M=2
MPM0q net24 net063 VDD VDD p15ll W=600n L=130n M=1
MPM1 net063 net24 VDD VDD p15ll W=600n L=130n M=1
MPM3 net016 net055 VDD VDD p15ll W=3u L=130n M=1
MPM2 net055 net063 VDD VDD p15ll W=1u L=130n M=1
MNM4 clk net016 gnd gnd n15ll W=1.5u L=130n M=2
MNM1 net063 net24 gnd gnd n15ll W=600n L=130n M=1
MNM0 net24 net063 gnd gnd n15ll W=600n L=130n M=1
MNM3 net016 net055 gnd gnd n15ll W=1.5u L=130n M=1
MNM2 net055 net063 gnd gnd n15ll W=600n L=130n M=1
RR0 net030 anten2 15 $[RP]
RR2 anten1 net031 15 $[RP]
.ENDS

************************************************************************
* Library Name: CD2101
* Cell Name:    dem100_v5
* View Name:    schematic
************************************************************************

.SUBCKT dem100_v5 A1 A4 VDD bias decode_en2 dem100 dem100_en gnd
*.PININFO A1:I A4:I VDD:I bias:I dem100_en:I gnd:I decode_en2:O dem100:O
MPM2 net0199 net0195 VDD VDD p15ll W=2u L=2u M=2
MPM0 net0195 dem100_en VDD VDD p15ll W=2u L=2u M=2
MPM4 net0118 net0160 VDD VDD p15ll W=1u L=500n M=1
MPM6 dem100 net0118 VDD VDD p15ll W=1u L=500n M=3
MNM0 net0195 dem100_en gnd gnd n15ll W=2u L=2u M=2
MNM2 net0199 net0195 gnd gnd n15ll W=2u L=2u M=2
MNM4 net0118 net0160 gnd gnd n15ll W=500n L=500n M=1
MNM6 dem100 net0118 gnd gnd n15ll W=500n L=500n M=3
MM0 net18 bias A1 A1 p33e2r W=1u L=3u M=1
MM11 decode_en2 net028 vdd3 vdd3 p33e2r W=2u L=1u M=1
MM2 net028 A4 vdd3 vdd3 p33e2r W=2u L=1u M=1
MM15 net028 decode_en2 vdd3 vdd3 p33e2r W=1u L=1u M=1
MM24 dem100v1 decode_en2 vdd3 vdd3 p33e2r W=2u L=1u M=1
MM27 net0111 net0236 A1 A1 p33e2r W=2u L=8u M=1
MM28 net0236 net0111 A1 A1 p33e2r W=2u L=8u M=1
MM33 vdd3 net0111 A1 A1 p33e2r W=10u L=800n M=2
MM36 net0160 dem100v1 VDD VDD p33e2r W=10u L=800n M=1
MM8 net18 net18 gnd gnd n33e2r W=1u L=1u M=1
MM4 net15 net18 gnd gnd n33e2r W=6u L=1u M=1
MM9 A4 A1 net15 gnd n33e2r W=10u L=2.5u M=1
MM12 net028 decode_en2 net0121 gnd n33e2r W=2u L=1u M=1
MM5 net043 A4 gnd gnd n33e2r W=2u L=1u M=1
MM10 decode_en2 net028 net035 gnd n33e2r W=2u L=1u M=1
MM1 net028 A4 net047 gnd n33e2r W=2u L=1u M=1
MM23 dem100v1 decode_en2 net077 gnd n33e2r W=2u L=1u M=1
MM3 net047 A4 net043 gnd n33e2r W=1u L=1u M=1
MM19 net0101 decode_en2 net097 gnd n33e2r W=2u L=1u M=1
MM7 net035 net028 net039 gnd n33e2r W=2u L=1u M=1
MM6 net039 net028 gnd gnd n33e2r W=2u L=1u M=1
MM13 net0121 decode_en2 net0117 gnd n33e2r W=2u L=1u M=1
MM18 net0105 decode_en2 net0109 gnd n33e2r W=2u L=1u M=1
MM17 net0109 decode_en2 net0113 gnd n33e2r W=2u L=1u M=1
MM14 net0117 decode_en2 net0105 gnd n33e2r W=2u L=1u M=1
MM16 net0113 decode_en2 net0101 gnd n33e2r W=2u L=1u M=1
MM20 net097 decode_en2 gnd gnd n33e2r W=2u L=1u M=1
MM22 net077 decode_en2 net081 gnd n33e2r W=2u L=1u M=1
MM25 net0236 net0195 gnd gnd n33e2r W=2u L=2u M=1
MM21 net081 decode_en2 gnd gnd n33e2r W=2u L=1u M=1
MM26 net0111 net0199 gnd gnd n33e2r W=40u L=2u M=1
MM34 dem100v1 net0111 gnd gnd n33e2r W=4u L=2.5u M=1
MM35 net0160 dem100v1 gnd gnd n33e2r W=10u L=600n M=1
XC5 A4 gnd pipe2r_ckt M=2 W=8u L=8u
.ENDS

************************************************************************
* Library Name: CD2101
* Cell Name:    rec_nmos100
* View Name:    schematic
************************************************************************

.SUBCKT rec_nmos100 A1 A3 A4 RF_Dout RF_Dout_H VDD anten1 anten2 gnd
*.PININFO RF_Dout:I RF_Dout_H:I VDD:I anten1:I anten2:I gnd:I A1:O A3:O A4:O
RR3 gnd gnd 10K $[RP]
RR0 anten1 net050 1K $[RP]
RR2 gnd gnd 5K $[RP]
RR8 anten2 net049 1K $[RP]
RR4 net054 gnd 250K $[RP]
RR5 a2 net044 1K $[RP]
MPM2 net105 net101 VDD VDD p15ll W=4u L=130n M=2
MPM0 net101 RF_Dout VDD VDD p15ll W=4u L=130n M=2
MPM6 net016 RF_Dout_H VDD VDD p15ll W=4u L=130n M=2
MPM7 net020 net016 VDD VDD p15ll W=4u L=130n M=2
MM9 net027 net024 A1 A1 p33e2r W=20u L=800n M=1
MM7 net024 net027 A1 A1 p33e2r W=20u L=800n M=1
MM21 net34 net92 A1 A1 p33e2r W=20u L=800n M=1
MM20 net92 net34 A1 A1 p33e2r W=20u L=800n M=1
MM10 net030 net030 a2 a2 p33e2r W=1u L=2u M=1
MM11 net054 net054 net030 net030 p33e2r W=10u L=1u M=1
MM8 net030 net92 a2 a2 p33e2r W=20u L=800n M=1
MM12 anten1 net027 gnd gnd n33e2r W=50u L=1u M=10
MM6 anten2 net027 gnd gnd n33e2r W=50u L=1u M=10
MM25 net049 net34 gnd gnd n33e2r W=50u L=1u M=1
MM26 net050 net34 gnd gnd n33e2r W=50u L=1u M=1
MM23 net92 net101 gnd gnd n33e2r W=20u L=600n M=1
MM14 anten2 net054 gnd gnd n33e2r W=100u L=1u M=10
MM24 net34 net105 gnd gnd n33e2r W=20u L=600n M=1
MM13 anten1 net054 gnd gnd n33e2r W=100u L=1u M=10
MM30 anten1 anten1 A1 gnd n33e2r W=100u L=1u M=1
MM31 anten2 anten2 A1 gnd n33e2r W=100u L=1u M=1
MM29 anten1 anten2 gnd gnd n33e2r W=100u L=1u M=1
MM27 anten2 anten2 a2 gnd n33e2r W=10u L=1u M=1
MM28 anten2 anten1 gnd gnd n33e2r W=100u L=1u M=1
MM19 anten1 anten1 a2 gnd n33e2r W=10u L=1u M=1
MM16 anten1 anten1 A3 gnd n33e2r W=10u L=1u M=1
MM15 anten2 anten2 A3 gnd n33e2r W=10u L=1u M=1
MM33 anten1 anten1 A4 gnd n33e2r W=10u L=1u M=1
MM32 anten2 anten2 A4 gnd n33e2r W=10u L=1u M=1
MM4 net024 net016 gnd gnd n33e2r W=20u L=600n M=1
MM5 net027 net020 gnd gnd n33e2r W=20u L=600n M=1
MNM2 net105 net101 gnd gnd n15ll W=4u L=130n M=2
MNM0 net101 RF_Dout gnd gnd n15ll W=4u L=130n M=2
MNM11 net016 RF_Dout_H gnd gnd n15ll W=4u L=130n M=2
MNM12 net020 net016 gnd gnd n15ll W=4u L=130n M=2
XC1 net044 net054 pipe2r_ckt M=1 W=31.2u L=6.174u
.ENDS

************************************************************************
* Library Name: CD2101
* Cell Name:    CD2001SLX2_A
* View Name:    schematic
************************************************************************

.SUBCKT CD2001SLX2_A RF_din RF_din_H SELVD VSS anten1 anten2 clk13m dem10_e
+ dem10_en dem10_s dem10_sen1 dem10_sen2 dem100 dem100_en por vdd
*.PININFO RF_din:I RF_din_H:I SELVD:I VSS:I anten1:I anten2:I dem10_en:I
*.PININFO dem10_sen1:I dem10_sen2:I dem100_en:I clk13m:O dem10_e:O dem10_s:O
*.PININFO dem100:O por:O vdd:O
XI15 A1 dem10_s dem10_e vdd net013 dem10_en decode_en2 dem10_sen1 dem10_sen2
+ net030 VSS / dem_v6_wv1
XI19 SELVD vdd A1 VSS por net012 net013 / LDO_NTAG
MNM0 VSS vdd VSS VSS n15ll W=100u L=10u M=40
XI3 vdd anten1 anten2 clk13m VSS / clk
XI2 A1 net086 vdd net012 decode_en2 dem100 dem100_en VSS / dem100_v5
XC0 A1 VSS mim1_ckt m=30 l=22.06u w=22.06u
XC2 A1 VSS mim1_ckt m=22 l=22.06u w=22.06u
XC1 anten1 anten2 mim1_ckt m=47 l=20.598u w=25u
XI0 A1 net030 net086 RF_din RF_din_H vdd anten1 anten2 VSS / rec_nmos100
.ENDS
